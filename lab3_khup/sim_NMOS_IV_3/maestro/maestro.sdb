ADE simulation setup
Run mode: Single Run, Sweeps and Corners
Tests:
  hw2_rpaillet:sim_NMOS_IV_3:1: hw2_rpaillet/sim_NMOS_IV_3/schematic, simulator hspiceD
    Variables: vgs = 0
