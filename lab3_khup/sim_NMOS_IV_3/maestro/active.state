ADE simulation setup
Test hw2_rpaillet:sim_NMOS_IV_3:1: hw2_rpaillet/sim_NMOS_IV_3/schematic, simulator hspiceD
  Models: $CDK_DIR/models/spectre/standalone/ami06N.m
  Variables: vgs = 0
  Analysis dc: sweep source start=0 stop=5
  Signals: /I0/D (terminal)
Run mode: Single Run, Sweeps and Corners
